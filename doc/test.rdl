addrmap FOOBAR {

  name = "Foobar SoC Register Map";

  default regwidth = 16;
  default hw = r;
  default sw = rw;

  // ---------------------------------------------------------------------------
  // Type definitions
  //---------------------------------------------------------------------------

  enum my_enum_t {
      e_foo = 2'd0 { name = "foo sticks"; };
      e_bar = 2'd1 { name = "bar tab"; };
      e_baz = 2'd2 { name = "baz woz ere"; };
      e_qux = 2'd3 { name = "qux like a duck"; };
  };

  // ---------------------------------------------------------------------------
  // Common field / reg definitions
  //---------------------------------------------------------------------------

  field unused {
    hw = r; sw = r;
  };

  reg PLACEHOLDER {
    name = "Placeholder";
    desc = "Placeholder register";
    unused unused0[15:0] = 0;
  };

  //---------------------------------------------------------------------------
  // Regfiles
  //---------------------------------------------------------------------------

  regfile R1 {
    name = "First regmap";
    desc = "Just a collection of registers";

    reg PLL_EN {
      unused unused0[15:8] = 0;

      field {
        desc = "This description uses some [b]SystemRDL[/b] [i]text
          formatting[/i] to format the text, for things like:

          [list]
            [*] Bold
            [*] Italic
            [*] Lists
          [/list]
        ";
      } F_RDL_DESC[7:5] = 0;

      field {
        encode = my_enum_t;
      } E_NUFF[4:3] = my_enum_t::e_bar;

      field {
        encode = my_enum_t;
        desc = "Demonstrates RDL enum";
      } E_NUM[2:1] = my_enum_t::e_foo;

      field {
        desc = "PLL enable";
      } EN[0:0] = 0;
    } PLL_EN @0x00;

    PLACEHOLDER PLACEHOLDER @0x02;
    PLACEHOLDER PLACEHOLDERS[4] @0x04 += 2;
  };

  regfile R2 {
    name = "Another register map";
    desc = "Nothing to see here";

    PLACEHOLDER PLACEHOLDER @0x00;
  };

  //---------------------------------------------------------------------------
  // Regfile Instantiations
  //---------------------------------------------------------------------------

  R1         R1   @0x000;
  R2         R2   @0x100;
};
