addrmap FOOBAR {

  name = "Foobar SoC Register Map";

  default regwidth = 16;
  default hw = r;
  default sw = rw;

  // ---------------------------------------------------------------------------
  // Type definitions
  //---------------------------------------------------------------------------

  enum my_enum_t {
      e_foo = 2'd0 { name = "foo sticks"; };
      e_bar = 2'd1 { name = "bar tab"; };
      e_baz = 2'd2 { name = "baz woz ere"; };
      e_qux = 2'd3 { name = "qux like a duck"; };
  };

  // ---------------------------------------------------------------------------
  // Common field / reg definitions
  //---------------------------------------------------------------------------

  field unused {
    hw = r; sw = r;
  };

  reg PLACEHOLDER {
    name = "Placeholder";
    desc = "Placeholder register";
    unused unused0[15:0] = 0;
  };

  //---------------------------------------------------------------------------
  // Regfiles
  //---------------------------------------------------------------------------

  regfile CLOCK {
    name = "Clock and PLL configuration";
    desc = "Registers to configure the PLL's multipliers / dividers, and any
      other clock dividers / muxes / gates, to derive all internal clocks from the
      REFCLK input.";

    reg PLL_EN {
      unused unused0[15:5] = 0;

      field {
        encode = my_enum_t;
      } E_NUFF[4:3] = my_enum_t::e_foo;

      field {
        encode = my_enum_t;
        desc = "Demonstrates RDL enum";
      } E_NUM[2:1] = my_enum_t::e_foo;

      field {
        desc = "PLL enable";
      } EN[0:0] = 0;
    } PLL_EN @0x00;
  };

  regfile OPS {
    name = "Operations";
    desc = "Configure and control the vector/matrix operation. VMM/VMI, single
      or batch. FSM timings. INT pin function. Input / output buffer access via JTAG.";

    PLACEHOLDER PLACEHOLDER @0x00;
  };

  regfile CALIB {
    name = "Calibration and overrides";
    desc = "Calibration values and overrides for analogue components.";

    PLACEHOLDER PLACEHOLDER @0x00;
  };

  regfile ATEST {
    name = "Analogue test structure control";
    desc = "Control of the analogue test array, and test bus muxes.";

    PLACEHOLDER PLACEHOLDER @0x00;
  };


  //---------------------------------------------------------------------------
  // Regfile Instantiations
  //---------------------------------------------------------------------------

  CLOCK         CLOCK   @0x000;
  OPS           OPS     @0x100;
  CALIB         CALIB   @0x200;
  ATEST         ATEST   @0x300;
};
